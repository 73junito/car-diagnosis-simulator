* AutoLearnPro Starting-System template v2.0.0 - open start-control circuit
* INDEPENDENT reference fixture. Hand-authored from
* data/circuit-templates/12v-starting-system-v2.json.
*
* Variant of starting-system-v2-healthy.cir with the control conductor
* (template element W_SWITCH_SOL) REMOVED. Opening an ideal conductor SPLITS the
* node it merged, so the former node 40 becomes two independent nodes:
*   40 = switch output (SW1_OUT)
*   45 = solenoid coil control input (SOL_COIL_PWR)
* The start switch itself remains closed, because the fault is in the wire and
* not in the switch.
*
* Because the coil can no longer be energised, the relay coupling contract opens
* the solenoid main contact, so the entire motor path is de-energised as well.
* Modelling the contact from the operating-state flag alone would incorrectly
* leave it closed here.
*
* Expected operating point (hand-calculated, all currents exactly zero):
*   v(20)=12.6 v(30)=12.6 v(40)=12.6 v(45)=0 v(50)=0
*   v(60)=12.6 v(70)=0 v(80)=0 v(85)=0 v(90)=0
*   i(vsrc)=0

VSRC 10 90 DC 12.600
RINT 20 10 8m
RNEGCABLE 90 0 0.6m
RFUSE 20 30 1m
RSWITCH 30 40 1m
RCOIL 45 50 3
RCOILRETURN 50 0 0.5m
RPOSCABLE 20 60 0.6m
RMOTORFEED 70 80 0.4m
RARMATURE 80 85 50m
RMOTORRETURN 85 0 0.4m

.control
op
print v(20) v(30) v(40) v(45) v(50) v(60) v(70) v(80) v(85) v(90)
print i(vsrc)
print @rint[i] @rnegcable[i] @rfuse[i] @rswitch[i] @rcoil[i] @rcoilreturn[i]
print @rposcable[i] @rmotorfeed[i] @rarmature[i] @rmotorreturn[i]
.endc

.end
